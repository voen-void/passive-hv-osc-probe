* HV probe model generated by tools/probe_sim.py from hv-probe-passive.kicad_pcb
* cable RG58 1.5 m, series R 0.0 ohm, pot 107456.0 ohm
* parasitic capacitances from the 3D field solver (Cp_*)

RR7_1 HV N01 2e+06
CC14_1 HV N01 4.7e-11 Lser=1.2e-09
RR8_2 N01 N02 2e+06
CC15_2 N01 N02 4.7e-11 Lser=1.2e-09
RR9_3 N02 N03 2e+06
CC16_3 N02 N03 4.7e-11 Lser=1.2e-09
RR10_4 N03 N04 2e+06
CC17_4 N03 N04 4.7e-11 Lser=1.2e-09
RR11_5 N04 N05 2e+06
CC18_5 N04 N05 4.7e-11 Lser=1.2e-09
RR12_6 N05 N06 2e+06
CC19_6 N05 N06 4.7e-11 Lser=1.2e-09
RR13_7 N06 N07 2e+06
CC20_7 N06 N07 4.7e-11 Lser=1.2e-09
RR14_8 N07 N08 2e+06
CC21_8 N07 N08 4.7e-11 Lser=1.2e-09
RR15_9 N08 N09 2e+06
CC22_9 N08 N09 4.7e-11 Lser=1.2e-09
RR16_10 N09 N10 2e+06
CC23_10 N09 N10 4.7e-11 Lser=1.2e-09
RR17_11 N10 N11 2e+06
CC24_11 N10 N11 4.7e-11 Lser=1.2e-09
RR18_12 N11 N12 2e+06
CC25_12 N11 N12 4.7e-11 Lser=1.2e-09
RR19_13 N12 N13 2e+06
CC26_13 N12 N13 4.7e-11 Lser=1.2e-09
RR20_14 N13 N14 2e+06
CC27_14 N13 N14 4.7e-11 Lser=1.2e-09
RR21_15 N14 N15 2e+06
CC28_15 N14 N15 4.7e-11 Lser=1.2e-09
RR22_16 N15 N16 2e+06
CC29_16 N15 N16 4.7e-11 Lser=1.2e-09
RR23_17 N16 N17 2e+06
CC30_17 N16 N17 4.7e-11 Lser=1.2e-09
RR24_18 N17 N18 2e+06
CC31_18 N17 N18 4.7e-11 Lser=1.2e-09
RR25_19 N18 N19 2e+06
CC32_19 N18 N19 4.7e-11 Lser=1.2e-09
RR26_20 N19 OUT 2e+06
CC33_20 N19 OUT 4.7e-11 Lser=1.2e-09
RR28_21 0 OUT 56000
RR27_22 0 Net__R27_Pad2 56000
CC35_21 0 OUT 3.3e-10 Lser=1e-09
CC34_22 0 OUT 6.8e-10 Lser=1e-09
CC13_23 0 OUT 3.525e-11 Lser=3e-09
RRV2_23 OUT Net__R27_Pad2 107456
CCp_GND_HV_24 0 HV 2.75449e-12
CCp_GND_N01_25 0 N01 1.21099e-12
CCp_GND_N02_26 0 N02 1.21204e-12
CCp_GND_N03_27 0 N03 1.22845e-12
CCp_GND_N04_28 0 N04 1.22666e-12
CCp_GND_N05_29 0 N05 1.22621e-12
CCp_GND_N06_30 0 N06 1.22524e-12
CCp_GND_N07_31 0 N07 1.22585e-12
CCp_GND_N08_32 0 N08 1.22888e-12
CCp_GND_N09_33 0 N09 1.21492e-12
CCp_GND_N10_34 0 N10 1.21499e-12
CCp_GND_N11_35 0 N11 1.21391e-12
CCp_GND_N12_36 0 N12 1.21397e-12
CCp_GND_N13_37 0 N13 1.21427e-12
CCp_GND_N14_38 0 N14 1.22989e-12
CCp_GND_N15_39 0 N15 1.22621e-12
CCp_GND_N16_40 0 N16 1.22541e-12
CCp_GND_N17_41 0 N17 1.22631e-12
CCp_GND_N18_42 0 N18 1.23348e-12
CCp_GND_N19_43 0 N19 1.28176e-12
CCp_GND_OUT_44 0 OUT 4.41211e-12
CCp_GND_Net__R27_Pad2_45 0 Net__R27_Pad2 7.29544e-13
CCp_HV_N01_46 HV N01 3.95792e-13
CCp_HV_N02_47 HV N02 3.26015e-14
CCp_HV_N03_48 HV N03 5.01466e-15
CCp_HV_N04_49 HV N04 8.00563e-16
CCp_HV_N05_50 HV N05 1.33099e-16
CCp_HV_N06_51 HV N06 2.24712e-17
CCp_N01_N02_52 N01 N02 3.70321e-13
CCp_N01_N03_53 N01 N03 2.74712e-14
CCp_N01_N04_54 N01 N04 3.96993e-15
CCp_N01_N05_55 N01 N05 6.38911e-16
CCp_N01_N06_56 N01 N06 1.05858e-16
CCp_N01_N07_57 N01 N07 1.78533e-17
CCp_N02_N03_58 N02 N03 3.70307e-13
CCp_N02_N04_59 N02 N04 2.63331e-14
CCp_N02_N05_60 N02 N05 3.90327e-15
CCp_N02_N06_61 N02 N06 6.28255e-16
CCp_N02_N07_62 N02 N07 1.04311e-16
CCp_N02_N08_63 N02 N08 1.71007e-17
CCp_N03_N04_64 N03 N04 3.41164e-13
CCp_N03_N05_65 N03 N05 2.67594e-14
CCp_N03_N06_66 N03 N06 3.9525e-15
CCp_N03_N07_67 N03 N07 6.3663e-16
CCp_N03_N08_68 N03 N08 1.028e-16
CCp_N03_N09_69 N03 N09 1.71094e-17
CCp_N04_N05_70 N04 N05 3.543e-13
CCp_N04_N06_71 N04 N06 2.74329e-14
CCp_N04_N07_72 N04 N07 4.06099e-15
CCp_N04_N08_73 N04 N08 6.38122e-16
CCp_N04_N09_74 N04 N09 1.04618e-16
CCp_N04_N10_75 N04 N10 1.7781e-17
CCp_N05_N06_76 N05 N06 3.5455e-13
CCp_N05_N07_77 N05 N07 2.73838e-14
CCp_N05_N08_78 N05 N08 3.95573e-15
CCp_N05_N09_79 N05 N09 6.29522e-16
CCp_N05_N10_80 N05 N10 1.05372e-16
CCp_N05_N11_81 N05 N11 1.78572e-17
CCp_N06_N07_82 N06 N07 3.53974e-13
CCp_N06_N08_83 N06 N08 2.67007e-14
CCp_N06_N09_84 N06 N09 3.90095e-15
CCp_N06_N10_85 N06 N10 6.345e-16
CCp_N06_N11_86 N06 N11 1.05913e-16
CCp_N06_N12_87 N06 N12 1.80045e-17
CCp_N07_N08_88 N07 N08 3.4114e-13
CCp_N07_N09_89 N07 N09 2.63443e-14
CCp_N07_N10_90 N07 N10 3.94682e-15
CCp_N07_N11_91 N07 N11 6.40803e-16
CCp_N07_N12_92 N07 N12 1.07363e-16
CCp_N07_N13_93 N07 N13 1.82527e-17
CCp_N08_N09_94 N08 N09 3.70412e-13
CCp_N08_N10_95 N08 N10 2.7395e-14
CCp_N08_N11_96 N08 N11 4.06607e-15
CCp_N08_N12_97 N08 N12 6.60235e-16
CCp_N08_N13_98 N08 N13 1.10425e-16
CCp_N08_N14_99 N08 N14 1.88794e-17
CCp_N09_N10_100 N09 N10 3.6965e-13
CCp_N09_N11_101 N09 N11 2.72375e-14
CCp_N09_N12_102 N09 N12 4.05229e-15
CCp_N09_N13_103 N09 N13 6.57934e-16
CCp_N09_N14_104 N09 N14 1.10756e-16
CCp_N09_N15_105 N09 N15 1.8301e-17
CCp_N10_N11_106 N10 N11 3.69423e-13
CCp_N10_N12_107 N10 N12 2.7194e-14
CCp_N10_N13_108 N10 N13 4.04735e-15
CCp_N10_N14_109 N10 N14 6.61557e-16
CCp_N10_N15_110 N10 N15 1.0757e-16
CCp_N10_N16_111 N10 N16 1.80084e-17
CCp_N11_N12_112 N11 N12 3.69415e-13
CCp_N11_N13_113 N11 N13 2.7179e-14
CCp_N11_N14_114 N11 N14 4.07208e-15
CCp_N11_N15_115 N11 N15 6.42058e-16
CCp_N11_N16_116 N11 N16 1.05942e-16
CCp_N11_N17_117 N11 N17 1.78522e-17
CCp_N12_N13_118 N12 N13 3.69309e-13
CCp_N12_N14_119 N12 N14 2.73518e-14
CCp_N12_N15_120 N12 N15 3.9435e-15
CCp_N12_N16_121 N12 N16 6.3279e-16
CCp_N12_N17_122 N12 N17 1.05014e-16
CCp_N12_N18_123 N12 N18 1.77084e-17
CCp_N13_N14_124 N13 N14 3.70537e-13
CCp_N13_N15_125 N13 N15 2.64004e-14
CCp_N13_N16_126 N13 N16 3.9006e-15
CCp_N13_N17_127 N13 N17 6.2879e-16
CCp_N13_N18_128 N13 N18 1.04408e-16
CCp_N13_N19_129 N13 N19 1.71879e-17
CCp_N14_N15_130 N14 N15 3.41398e-13
CCp_N14_N16_131 N14 N16 2.67504e-14
CCp_N14_N17_132 N14 N17 3.958e-15
CCp_N14_N18_133 N14 N18 6.37919e-16
CCp_N14_N19_134 N14 N19 1.03452e-16
CCp_N14_OUT_135 N14 OUT 1.5243e-17
CCp_N15_N16_136 N15 N16 3.54049e-13
CCp_N15_N17_137 N15 N17 2.73721e-14
CCp_N15_N18_138 N15 N18 4.05612e-15
CCp_N15_N19_139 N15 N19 6.40138e-16
CCp_N15_OUT_140 N15 OUT 9.29808e-17
CCp_N16_N17_141 N16 N17 3.54562e-13
CCp_N16_N18_142 N16 N18 2.73765e-14
CCp_N16_N19_143 N16 N19 3.97193e-15
CCp_N16_OUT_144 N16 OUT 5.60455e-16
CCp_N17_N18_145 N17 N18 3.54063e-13
CCp_N17_N19_146 N17 N19 2.68463e-14
CCp_N17_OUT_147 N17 OUT 3.48208e-15
CCp_N18_N19_148 N18 N19 3.41978e-13
CCp_N18_OUT_149 N18 OUT 2.36758e-14
CCp_N19_OUT_150 N19 OUT 3.46472e-13
CCp_OUT_Net__R27_Pad2_151 OUT Net__R27_Pad2 9.59096e-14
O1 OUT 0 SCOPE 0 CABLE
.model CABLE LTRA(len=1.5 R=0.048 L=2.527e-07 C=1.0108e-10)
* note: LTRA has no skin effect; probe_sim.py models R ~ sqrt(f)
RRscope_24 SCOPE 0 1e+06
CCscope_152 SCOPE 0 1.5e-11

V1 HV 0 AC 1 PULSE(0 1 0 1n 1n 1 2)
.ac dec 100 1 1G
* .tran 0 2u 0 0.1n
.options plotwinsize=0

.meas AC g0 FIND mag(V(SCOPE)) AT 100
.meas AC g1 FIND mag(V(SCOPE)) AT 10000
.meas AC g2 FIND mag(V(SCOPE)) AT 1e+06
.meas AC g3 FIND mag(V(SCOPE)) AT 1e+07
.meas AC g4 FIND mag(V(SCOPE)) AT 3e+07
.meas AC g5 FIND mag(V(SCOPE)) AT 1e+08
.end
