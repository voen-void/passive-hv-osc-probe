* HV probe model generated by tools/probe_sim.py from hv-probe-passive.kicad_pcb
* cable RG58 1.5 m, back termination 49.9 ohm, pot 107488.0 ohm
* parasitic capacitances from the 3D field solver (Cp_*)
* dispersion/loss of the dielectrics is NOT included: parasitics at their field-solve value

RR7_1 HV N01 2e+06
CC14_1 HV N01 4.7e-11 Lser=1e-09 Rser=0.05
RR8_2 N01 N02 2e+06
CC15_2 N01 N02 4.7e-11 Lser=1e-09 Rser=0.05
RR9_3 N02 N03 2e+06
CC16_3 N02 N03 4.7e-11 Lser=1e-09 Rser=0.05
RR10_4 N03 N04 2e+06
CC17_4 N03 N04 4.7e-11 Lser=1e-09 Rser=0.05
RR11_5 N04 N05 2e+06
CC18_5 N04 N05 4.7e-11 Lser=1e-09 Rser=0.05
RR12_6 N05 N06 2e+06
CC19_6 N05 N06 4.7e-11 Lser=1e-09 Rser=0.05
RR13_7 N06 N07 2e+06
CC20_7 N06 N07 4.7e-11 Lser=1e-09 Rser=0.05
RR14_8 N07 N08 2e+06
CC21_8 N07 N08 4.7e-11 Lser=1e-09 Rser=0.05
RR15_9 N08 N09 2e+06
CC22_9 N08 N09 4.7e-11 Lser=1e-09 Rser=0.05
RR16_10 N09 N10 2e+06
CC23_10 N09 N10 4.7e-11 Lser=1e-09 Rser=0.05
RR17_11 N10 N11 2e+06
CC24_11 N10 N11 4.7e-11 Lser=1e-09 Rser=0.05
RR18_12 N11 N12 2e+06
CC25_12 N11 N12 4.7e-11 Lser=1e-09 Rser=0.05
RR19_13 N12 N13 2e+06
CC26_13 N12 N13 4.7e-11 Lser=1e-09 Rser=0.05
RR20_14 N13 N14 2e+06
CC27_14 N13 N14 4.7e-11 Lser=1e-09 Rser=0.05
RR21_15 N14 N15 2e+06
CC28_15 N14 N15 4.7e-11 Lser=1e-09 Rser=0.05
RR22_16 N15 N16 2e+06
CC29_16 N15 N16 4.7e-11 Lser=1e-09 Rser=0.05
RR23_17 N16 N17 2e+06
CC30_17 N16 N17 4.7e-11 Lser=1e-09 Rser=0.05
RR24_18 N17 N18 2e+06
CC31_18 N17 N18 4.7e-11 Lser=1e-09 Rser=0.05
RR25_19 N18 N19 2e+06
CC32_19 N18 N19 4.7e-11 Lser=1e-09 Rser=0.05
RR26_20 N19 BOT 2e+06
CC33_20 N19 BOT 4.7e-11 Lser=1e-09 Rser=0.05
RR29_21 OUT BOT 49.9
RR28_22 0 BOT 56000
RR27_23 0 Net_R27_Pad2 56000
CC35_21 0 BOT 3.3e-10 Lser=7.36e-10 Rser=0.0635
CC34_22 0 BOT 6.8e-10 Lser=7.36e-10 Rser=0.0635
CC13_23 0 BOT 3.525e-11 Lser=3e-09 Rser=0.204
CD1_24 0 BOT 2e-11
RRV2_24 BOT Net_R27_Pad2 107488
Cp_HV_GND HV 0 2.35213e-12
Cp_HV_N01 HV N01 3.12367e-13
Cp_HV_N02 HV N02 2.60192e-14
Cp_HV_N03 HV N03 3.68528e-15
Cp_HV_N04 HV N04 5.69848e-16
Cp_HV_N05 HV N05 9.14725e-17
Cp_HV_N06 HV N06 1.46589e-17
Cp_OUT_GND OUT 0 6.23448e-13
Cp_OUT_N19 OUT N19 5.01245e-17
Cp_OUT_BOT OUT BOT 1.42927e-14
Cp_OUT_Net_R27_Pad2 OUT Net_R27_Pad2 1.59433e-16
Cp_N01_GND N01 0 8.56638e-13
Cp_N01_N02 N01 N02 2.82405e-13
Cp_N01_N03 N01 N03 1.98089e-14
Cp_N01_N04 N01 N04 2.80176e-15
Cp_N01_N05 N01 N05 4.28888e-16
Cp_N01_N06 N01 N06 6.75231e-17
Cp_N01_N07 N01 N07 1.03452e-17
Cp_N02_GND N02 0 8.76846e-13
Cp_N02_N03 N02 N03 2.60527e-13
Cp_N02_N04 N02 N04 2.00218e-14
Cp_N02_N05 N02 N05 2.81968e-15
Cp_N02_N06 N02 N06 4.32848e-16
Cp_N02_N07 N02 N07 6.55075e-17
Cp_N02_N08 N02 N08 1.06688e-17
Cp_N03_GND N03 0 8.762e-13
Cp_N03_N04 N03 N04 2.70323e-13
Cp_N03_N05 N03 N05 2.04224e-14
Cp_N03_N06 N03 N06 2.88956e-15
Cp_N03_N07 N03 N07 4.27402e-16
Cp_N03_N08 N03 N08 6.89531e-17
Cp_N03_N09 N03 N09 1.08494e-17
Cp_N04_GND N04 0 8.76666e-13
Cp_N04_N05 N04 N05 2.70921e-13
Cp_N04_N06 N04 N06 2.04513e-14
Cp_N04_N07 N04 N07 2.78841e-15
Cp_N04_N08 N04 N08 4.38667e-16
Cp_N04_N09 N04 N09 6.81074e-17
Cp_N04_N10 N04 N10 1.09371e-17
Cp_N05_GND N05 0 8.76528e-13
Cp_N05_N06 N05 N06 2.70717e-13
Cp_N05_N07 N05 N07 1.9771e-14
Cp_N05_N08 N05 N08 2.86612e-15
Cp_N05_N09 N05 N09 4.33519e-16
Cp_N05_N10 N05 N10 6.86962e-17
Cp_N05_N11 N05 N11 1.10636e-17
Cp_N06_GND N06 0 8.78488e-13
Cp_N06_N07 N06 N07 2.5932e-13
Cp_N06_N08 N06 N08 2.04366e-14
Cp_N06_N09 N06 N09 2.84705e-15
Cp_N06_N10 N06 N10 4.40256e-16
Cp_N06_N11 N06 N11 6.9998e-17
Cp_N06_N12 N06 N12 1.12609e-17
Cp_N07_GND N07 0 8.57861e-13
Cp_N07_N08 N07 N08 2.58406e-13
Cp_N07_N09 N07 N09 1.95129e-14
Cp_N07_N10 N07 N10 2.78128e-15
Cp_N07_N11 N07 N11 4.3114e-16
Cp_N07_N12 N07 N12 6.8453e-17
Cp_N07_N13 N07 N13 1.10281e-17
Cp_N08_GND N08 0 8.79188e-13
Cp_N08_N09 N08 N09 2.81334e-13
Cp_N08_N10 N08 N10 2.04038e-14
Cp_N08_N11 N08 N11 2.90186e-15
Cp_N08_N12 N08 N12 4.48603e-16
Cp_N08_N13 N08 N13 7.14074e-17
Cp_N08_N14 N08 N14 1.10516e-17
Cp_N09_GND N09 0 8.69057e-13
Cp_N09_N10 N09 N10 2.8088e-13
Cp_N09_N11 N09 N11 2.03575e-14
Cp_N09_N12 N09 N12 2.89171e-15
Cp_N09_N13 N09 N13 4.4828e-16
Cp_N09_N14 N09 N14 6.83604e-17
Cp_N09_N15 N09 N15 1.12434e-17
Cp_N10_GND N10 0 8.68674e-13
Cp_N10_N11 N10 N11 2.80988e-13
Cp_N10_N12 N10 N12 2.03756e-14
Cp_N10_N13 N10 N13 2.90133e-15
Cp_N10_N14 N10 N14 4.30545e-16
Cp_N10_N15 N10 N15 6.99628e-17
Cp_N10_N16 N10 N16 1.10616e-17
Cp_N11_GND N11 0 8.6899e-13
Cp_N11_N12 N11 N12 2.81e-13
Cp_N11_N13 N11 N13 2.04324e-14
Cp_N11_N14 N11 N14 2.78092e-15
Cp_N11_N15 N11 N15 4.40397e-16
Cp_N11_N16 N11 N16 6.87783e-17
Cp_N11_N17 N11 N17 1.09826e-17
Cp_N12_GND N12 0 8.69398e-13
Cp_N12_N13 N12 N13 2.81398e-13
Cp_N12_N14 N12 N14 1.95089e-14
Cp_N12_N15 N12 N15 2.84806e-15
Cp_N12_N16 N12 N16 4.34146e-16
Cp_N12_N17 N12 N17 6.83656e-17
Cp_N12_N18 N12 N18 1.04444e-17
Cp_N13_GND N13 0 8.79065e-13
Cp_N13_N14 N13 N14 2.58305e-13
Cp_N13_N15 N13 N15 2.0408e-14
Cp_N13_N16 N13 N16 2.86619e-15
Cp_N13_N17 N13 N17 4.39617e-16
Cp_N13_N18 N13 N18 6.62341e-17
Cp_N13_N19 N13 N19 1.08809e-17
Cp_N14_GND N14 0 8.57576e-13
Cp_N14_N15 N14 N15 2.59225e-13
Cp_N14_N16 N14 N16 1.97637e-14
Cp_N14_N17 N14 N17 2.79327e-15
Cp_N14_N18 N14 N18 4.10492e-16
Cp_N14_N19 N14 N19 6.64787e-17
Cp_N15_GND N15 0 8.7851e-13
Cp_N15_N16 N15 N16 2.70746e-13
Cp_N15_N17 N15 N17 2.05058e-14
Cp_N15_N18 N15 N18 2.77882e-15
Cp_N15_N19 N15 N19 4.39229e-16
Cp_N15_BOT N15 BOT 5.96456e-17
Cp_N16_GND N16 0 8.77439e-13
Cp_N16_N17 N16 N17 2.71222e-13
Cp_N16_N18 N16 N18 1.96668e-14
Cp_N16_N19 N16 N19 2.86489e-15
Cp_N16_BOT N16 BOT 3.79224e-16
Cp_N17_GND N17 0 8.83709e-13
Cp_N17_N18 N17 N18 2.60532e-13
Cp_N17_N19 N17 N19 2.05645e-14
Cp_N17_BOT N17 BOT 2.50944e-15
Cp_N18_GND N18 0 8.61948e-13
Cp_N18_N19 N18 N19 2.58622e-13
Cp_N18_BOT N18 BOT 1.71916e-14
Cp_N19_GND N19 0 9.21588e-13
Cp_N19_BOT N19 BOT 2.60603e-13
Cp_BOT_GND BOT 0 3.63276e-12
Cp_BOT_Net_R27_Pad2 BOT Net_R27_Pad2 9.55504e-14
Cp_Net_R27_Pad2_GND Net_R27_Pad2 0 7.31626e-13
O1 OUT 0 SCOPE 0 CABLE
.model CABLE LTRA(len=1.5 R=0.048 L=2.527e-07 C=1.0108e-10)
* note: LTRA has no skin effect; probe_sim.py models R ~ sqrt(f)
RRscope_25 SCOPE 0 1e+06
CCscope_25 SCOPE 0 1.5e-11

V1 HV 0 AC 1 PULSE(0 1 0 1n 1n 1 2)
.ac dec 100 1 1G
* .tran 0 2u 0 0.1n
.options plotwinsize=0

.meas AC g0 FIND mag(V(SCOPE)) AT 100
.meas AC g1 FIND mag(V(SCOPE)) AT 10000
.meas AC g2 FIND mag(V(SCOPE)) AT 1e+06
.meas AC g3 FIND mag(V(SCOPE)) AT 1e+07
.meas AC g4 FIND mag(V(SCOPE)) AT 3e+07
.meas AC g5 FIND mag(V(SCOPE)) AT 1e+08
.end
